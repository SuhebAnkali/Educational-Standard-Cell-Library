* DFF SETUP characterization.
* Edge 1 @ 5 ns captures D=0 and initialises Q low. D then rises at TD and the
* capturing edge is at 20 ns, so the setup separation under test is 20ns - TD.
.lib pdk/libs.tech/ngspice/sky130.lib.spice __CORNER__
.include cells.spice
.param VDD=__VDD__
.param TRF=__TRF__
.param CL=__CL__
.param TD=__TD__
.temp __TEMP__
Vdd  VPWR 0 {VDD}
Vgnd VGND 0 0
Vclk CLK 0 PULSE(0 {VDD} 5n {TRF} {TRF} 4n 15n)
Vd   D   0 PWL(0 0  {TD} 0  {TD+TRF} {VDD}  34n {VDD})
XDUT D CLK Q VPWR VGND dff
CLOAD Q 0 {CL}
.tran 2p 32n
.control
set filetype=ascii
run
meas tran tcq trig v(CLK) val=__V50__ rise=1 td=12n targ v(Q) val=__V50__ rise=1 td=12n
meas tran qfinal find v(Q) at=30n
.endc
.end
